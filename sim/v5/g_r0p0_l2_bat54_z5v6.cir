* 40 m 5 W single-ended GaN class E PA, tank + L-match (pa40-classe.kicad_sch rev A)
* Values from the schematic / Page; losses are estimates (see comments)
.include EPC2036_ngspice.lib
.param per=1.422475106685633e-07
* Supply 12.0 V, ideal source with 10 mOhm (estimate)
VDD vdd_src 0 12.0
RSRC vdd_src vdd 0.01
* C14/C15 decoupling at L1 cold end (placeholders), with 10 mOhm ESR (estimate)
C14 vdd c14 0.1u ic=12
RC14 c14 0 0.01
C15 vdd c15 10n ic=12
RC15 c15 0 0.01
* L1 FT-50-61 26t #24, 47 uH: copper 37 mOhm (7 mW at 0.434 A, Page), core Rp 277 kOhm at 7.03 MHz (Page)
L1 vdd l1m 47u ic=0.35
RL1 l1m d 0.037
RP1 vdd d 277k
* Q1 EPC2036 (EPC model)
XQ1 g d 0 EPC2036
* C1 shunt (external), ESR 20 mOhm (Page estimate for C0G)
C1 d c1m 2.6e-10
RC1 c1m 0 0.02
* C2 series 424.5 pF, ESR 20 mOhm
C2 d c2m 424.5p ic=12
RC2 c2m n2 0.02
* L2 T-80-6 22t #16, 2.18 uH, Qu 330 at 7.03 MHz -> Rs = 0.292 Ohm (Page)
L2 n2 l2m 2.122e-06
RL2 l2m out 0.292
* C3 731 pF shunt at 50 Ohm side, ESR 20 mOhm
C3 out c3m 731p
RC3 c3m 0 0.02
* 3-pole elliptic LPF as drawn (C16, L3||C17+C18, C19); ESRs from Q at 7.03 MHz
VFIN out fin 0
C16 fin c16m 270p
RC16 c16m 0 0.08385
L3 fin l3m 7.605000e-07
RL3 l3m rf 0.10497
C17 fin c17m 150p
RC17 c17m rf 0.15093
C18 fin c18m 18p
RC18 c18m rf 1.25774
C19 rf c19m 270p
RC19 c19m 0 0.08385
RLOAD rf 0 50
VSENSE rf load 0
RDUMMY load 0 1e12

* Gate drive: 74LVC1G17 at 5 V as ideal 0-5 V square, 1 ns edges, 7 Ohm output (estimate, as v2).
* R1 = 0.0 Ohm; gate loop L = 2 nH (assumed, lumped between R1 and the Q1 gate pad); clamp = bat54+z5v6
VDRV drv 0 PULSE(0 5 0 1n 1n {per/2-1n} {per})
RDRV drv g1 7
R1 g1 g2 0.0001
LG g2 g 2n
VCL g gc 0
DCL1 0 gc DI_BAT54W
XZ1 0 gc DI_BZX84C5V6
* Diodes Inc. SPICE models (diodes.com/spice/download/...): BZX84C5V6 (886), BZX84C6V2 (887), BAT54W (438)
.include models/BZX84C5V6.spice.txt
.include models/BZX84C6V2.spice.txt
.include models/BAT54W.spice.txt
.options reltol=1e-3 itl4=100 gmin=1e-12
.tran 0.05n 4.267425320056899e-05 0 0.05n uic
.control
set filetype=ascii
run
linearize v(d) v(g) v(rf) i(VDD) i(VDRV) v(out) i(VFIN) v(drv) i(VCL) v(xq1.gate)
wrdata g_r0p0_l2_bat54_z5v6.dat v(d) v(g) v(rf) i(VDD) i(VDRV) v(out) i(VFIN) v(drv) i(VCL) v(xq1.gate)
.endc
.end
